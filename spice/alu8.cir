* Generated by scripts/generate_netlist.py
.subckt alu8 a0 a1 a2 a3 a4 a5 a6 a7 b0 b1 b2 b3 b4 b5 b6 b7 op0 op1 op2 y0 y1 y2 y3 y4 y5 y6 y7 carry overflow zero vdd vss
Xbsub0 b0 op0 bs0 vdd vss xor2
Xfa0 a0 bs0 op0 s0 c1 vdd vss fulladd
Xand0 a0 b0 and0 vdd vss and2
Xor0 a0 b0 or0 vdd vss or2
Xxor0 a0 b0 xor0 vdd vss xor2
Xnot0 a0 not0 vdd vss inv
Xlogic0 and0 or0 op0 l0 vdd vss mux2
Xunary0 xor0 not0 op0 u0 vdd vss mux2
Xshift0 vss a1 op0 h0 vdd vss mux2
Xlo0 s0 l0 op1 lo0 vdd vss mux2
Xhi0 u0 h0 op1 hi0 vdd vss mux2
Xout0 lo0 hi0 op2 y0 vdd vss mux2
Xbsub1 b1 op0 bs1 vdd vss xor2
Xfa1 a1 bs1 c1 s1 c2 vdd vss fulladd
Xand1 a1 b1 and1 vdd vss and2
Xor1 a1 b1 or1 vdd vss or2
Xxor1 a1 b1 xor1 vdd vss xor2
Xnot1 a1 not1 vdd vss inv
Xlogic1 and1 or1 op0 l1 vdd vss mux2
Xunary1 xor1 not1 op0 u1 vdd vss mux2
Xshift1 a0 a2 op0 h1 vdd vss mux2
Xlo1 s1 l1 op1 lo1 vdd vss mux2
Xhi1 u1 h1 op1 hi1 vdd vss mux2
Xout1 lo1 hi1 op2 y1 vdd vss mux2
Xbsub2 b2 op0 bs2 vdd vss xor2
Xfa2 a2 bs2 c2 s2 c3 vdd vss fulladd
Xand2 a2 b2 and2 vdd vss and2
Xor2 a2 b2 or2 vdd vss or2
Xxor2 a2 b2 xor2 vdd vss xor2
Xnot2 a2 not2 vdd vss inv
Xlogic2 and2 or2 op0 l2 vdd vss mux2
Xunary2 xor2 not2 op0 u2 vdd vss mux2
Xshift2 a1 a3 op0 h2 vdd vss mux2
Xlo2 s2 l2 op1 lo2 vdd vss mux2
Xhi2 u2 h2 op1 hi2 vdd vss mux2
Xout2 lo2 hi2 op2 y2 vdd vss mux2
Xbsub3 b3 op0 bs3 vdd vss xor2
Xfa3 a3 bs3 c3 s3 c4 vdd vss fulladd
Xand3 a3 b3 and3 vdd vss and2
Xor3 a3 b3 or3 vdd vss or2
Xxor3 a3 b3 xor3 vdd vss xor2
Xnot3 a3 not3 vdd vss inv
Xlogic3 and3 or3 op0 l3 vdd vss mux2
Xunary3 xor3 not3 op0 u3 vdd vss mux2
Xshift3 a2 a4 op0 h3 vdd vss mux2
Xlo3 s3 l3 op1 lo3 vdd vss mux2
Xhi3 u3 h3 op1 hi3 vdd vss mux2
Xout3 lo3 hi3 op2 y3 vdd vss mux2
Xbsub4 b4 op0 bs4 vdd vss xor2
Xfa4 a4 bs4 c4 s4 c5 vdd vss fulladd
Xand4 a4 b4 and4 vdd vss and2
Xor4 a4 b4 or4 vdd vss or2
Xxor4 a4 b4 xor4 vdd vss xor2
Xnot4 a4 not4 vdd vss inv
Xlogic4 and4 or4 op0 l4 vdd vss mux2
Xunary4 xor4 not4 op0 u4 vdd vss mux2
Xshift4 a3 a5 op0 h4 vdd vss mux2
Xlo4 s4 l4 op1 lo4 vdd vss mux2
Xhi4 u4 h4 op1 hi4 vdd vss mux2
Xout4 lo4 hi4 op2 y4 vdd vss mux2
Xbsub5 b5 op0 bs5 vdd vss xor2
Xfa5 a5 bs5 c5 s5 c6 vdd vss fulladd
Xand5 a5 b5 and5 vdd vss and2
Xor5 a5 b5 or5 vdd vss or2
Xxor5 a5 b5 xor5 vdd vss xor2
Xnot5 a5 not5 vdd vss inv
Xlogic5 and5 or5 op0 l5 vdd vss mux2
Xunary5 xor5 not5 op0 u5 vdd vss mux2
Xshift5 a4 a6 op0 h5 vdd vss mux2
Xlo5 s5 l5 op1 lo5 vdd vss mux2
Xhi5 u5 h5 op1 hi5 vdd vss mux2
Xout5 lo5 hi5 op2 y5 vdd vss mux2
Xbsub6 b6 op0 bs6 vdd vss xor2
Xfa6 a6 bs6 c6 s6 c7 vdd vss fulladd
Xand6 a6 b6 and6 vdd vss and2
Xor6 a6 b6 or6 vdd vss or2
Xxor6 a6 b6 xor6 vdd vss xor2
Xnot6 a6 not6 vdd vss inv
Xlogic6 and6 or6 op0 l6 vdd vss mux2
Xunary6 xor6 not6 op0 u6 vdd vss mux2
Xshift6 a5 a7 op0 h6 vdd vss mux2
Xlo6 s6 l6 op1 lo6 vdd vss mux2
Xhi6 u6 h6 op1 hi6 vdd vss mux2
Xout6 lo6 hi6 op2 y6 vdd vss mux2
Xbsub7 b7 op0 bs7 vdd vss xor2
Xfa7 a7 bs7 c7 s7 c8 vdd vss fulladd
Xand7 a7 b7 and7 vdd vss and2
Xor7 a7 b7 or7 vdd vss or2
Xxor7 a7 b7 xor7 vdd vss xor2
Xnot7 a7 not7 vdd vss inv
Xlogic7 and7 or7 op0 l7 vdd vss mux2
Xunary7 xor7 not7 op0 u7 vdd vss mux2
Xshift7 a6 vss op0 h7 vdd vss mux2
Xlo7 s7 l7 op1 lo7 vdd vss mux2
Xhi7 u7 h7 op1 hi7 vdd vss mux2
Xout7 lo7 hi7 op2 y7 vdd vss mux2
Xarithlo op1 op2 arith vdd vss nor2
Xcarryarith arith c8 ca vdd vss and2
Xshiftcarry a7 a0 op0 cs vdd vss mux2
Xshiften op1 op2 sh vdd vss and2
Xcarryshift sh cs ch vdd vss and2
Xcarry ca ch carry vdd vss or2
Xoverraw c7 c8 ov vdd vss xor2
Xoverflow arith ov overflow vdd vss and2
Xzero1 y0 y1 z1 vdd vss or2
Xzero2 z1 y2 z2 vdd vss or2
Xzero3 z2 y3 z3 vdd vss or2
Xzero4 z3 y4 z4 vdd vss or2
Xzero5 z4 y5 z5 vdd vss or2
Xzero6 z5 y6 z6 vdd vss or2
Xzero7 z6 y7 z7 vdd vss or2
Xzero z7 zero vdd vss inv
.ends alu8
