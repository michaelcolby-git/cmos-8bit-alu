* Generic educational static CMOS library. NOT a foundry PDK.
* Dimensions are illustrative; SCALE changes all widths, not process geometry.
.param SCALE=1
.model N NMOS (LEVEL=1 VTO=0.45 KP=120u LAMBDA=0.04 CGSO=0.2n CGDO=0.2n)
.model P PMOS (LEVEL=1 VTO=-0.45 KP=50u LAMBDA=0.04 CGSO=0.2n CGDO=0.2n)
.subckt inv a y vdd vss
Mp y a vdd vdd P W={2.4u*SCALE} L=0.18u
Mn y a vss vss N W={1u*SCALE} L=0.18u
.ends inv
.subckt nand2 a b y vdd vss
Mp1 y a vdd vdd P W={2.4u*SCALE} L=0.18u
Mp2 y b vdd vdd P W={2.4u*SCALE} L=0.18u
Mn1 y a n vss N W={2u*SCALE} L=0.18u
Mn2 n b vss vss N W={2u*SCALE} L=0.18u
.ends nand2
.subckt nor2 a b y vdd vss
Mp1 n a vdd vdd P W={4.8u*SCALE} L=0.18u
Mp2 y b n vdd P W={4.8u*SCALE} L=0.18u
Mn1 y a vss vss N W={1u*SCALE} L=0.18u
Mn2 y b vss vss N W={1u*SCALE} L=0.18u
.ends nor2
.subckt and2 a b y vdd vss
Xn a b n vdd vss nand2
Xi n y vdd vss inv
.ends and2
.subckt or2 a b y vdd vss
Xn a b n vdd vss nor2
Xi n y vdd vss inv
.ends or2
.subckt xor2 a b y vdd vss
X0 a b n0 vdd vss nand2
X1 a n0 n1 vdd vss nand2
X2 b n0 n2 vdd vss nand2
X3 n1 n2 y vdd vss nand2
.ends xor2
.subckt mux2 a b s y vdd vss
Xi s sn vdd vss inv
X0 a sn n0 vdd vss nand2
X1 b s n1 vdd vss nand2
X2 n0 n1 y vdd vss nand2
.ends mux2
.subckt fulladd a b ci s co vdd vss
X0 a b p vdd vss xor2
X1 p ci s vdd vss xor2
X2 a b g vdd vss and2
X3 p ci h vdd vss and2
X4 g h co vdd vss or2
.ends fulladd
